VCC 1 0 DC 12
Vin 2 0 AC 1 SIN(0 1 1k)
Cc 2 3 10u
Rb1 1 4 100k
Rb2 4 0 24k
Rc 1 5 3.9k
Re 5 0 1k
Rl 5 6 2k

.end
